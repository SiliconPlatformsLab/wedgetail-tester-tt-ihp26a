/* vim: set filetype=systemrdl : */
property int_sig {
    // Internal Signal flag, used to prevent SW-read-only signals from being added
    // to the auto-generated port include file. Not to be confused with SystemRDL's
    // own internal/external keywords, which are meant for specifiying whether the
    // SystemRDL compiler should generate the register or not.

    type = boolean;
    component = field;
};

addrmap wedgetail_spi {
    name = "Wedgetail SPI";
    desc = "Wedgetail SPI interface for Wedgetail TCDE REV01";

    default sw = rw;
    default hw = r;
    default	int_sig = false;
    default accesswidth = 8;
    default regwidth = 8;

    reg {
        name = "Reset";
        field {
            desc = "When any value is written to this register, a power on reset will be performed on the
            entire device";
            sw = w;
            hw = r;
        } RESET[7:0] = 0;
    } SYS_CTRL;

    reg {
        name = "ECHO1";
        field {
            desc = "Read/write echo register, for SPI debugging";
        } DATA[7:0] = 0;
    } ECHO1;

    reg {
        name = "ECHO2";
        field {
            desc = "Read/write echo register, for SPI debugging";
        } DATA[7:0] = 0;
    } ECHO2;

    reg {
        name = "Ring Oscillator Enable Select";
        field {
            desc = "Select the bits enabled by the configurable ring oscillator.";
        } DATA[7:0];
    } ROSC_EN_SEL;
};
